* DAC0800 test 02 - all 256 codes and Table 3 (symmetrical offset binary)
*  a) unipolar, IOUT into an ideal transimpedance stage: monotonic, every
*     step 1 LSB +-1/2 LSB, IOUT + IOUTB = IFS = 255/256 IREF for every code
*  b) Figure 23 (op amp, RL = RL' = 5k, VREF = 10 V): EO = VREF*(-255/256 +
*     2X/256) - +9.960 / +0.040 / -0.040 / -9.960 V at 255 / 128 / 127 / 0
.include dac0800_ng.lib
Vp vp 0 15
Vm vm 0 -15
Vr vr 0 10
Vb1 b1 0 PWL(0 0 1e-06 0 1.005e-06 0 2e-06 0 2.005e-06 0 3e-06 0 3.005e-06 0 4e-06 0 4.005e-06 0 5e-06 0 5.005e-06 0 6e-06 0 6.005e-06 0 7e-06 0 7.005e-06 0 8e-06 0 8.005e-06 0 9e-06 0 9.005e-06 0 1e-05 0 1.0005e-05 0 1.1e-05 0 1.1005e-05 0 1.2e-05 0 1.2005e-05 0 1.3e-05 0 1.3005e-05 0 1.4e-05 0 1.4005e-05 0 1.5e-05 0 1.5005e-05 0 1.6e-05 0 1.6005e-05 0 1.7e-05 0 1.7005e-05 0 1.8e-05 0 1.8005e-05 0 1.9e-05 0 1.9005e-05 0 2e-05 0 2.0005e-05 0 2.1e-05 0 2.1005e-05 0 2.2e-05 0 2.2005e-05 0 2.3e-05 0 2.3005e-05 0 2.4e-05 0 2.4005e-05 0 2.5e-05 0 2.5005e-05 0 2.6e-05 0 2.6005e-05 0 2.7e-05 0 2.7005e-05 0 2.8e-05 0 2.8005e-05 0 2.9e-05 0 2.9005e-05 0 3e-05 0 3.0005e-05 0 3.1e-05 0 3.1005e-05 0 3.2e-05 0 3.2005e-05 0 3.3e-05 0 3.3005e-05 0 3.4e-05 0 3.4005e-05 0 3.5e-05 0 3.5005e-05 0 3.6e-05 0 3.6005e-05 0 3.7e-05 0 3.7005e-05 0 3.8e-05 0 3.8005e-05 0 3.9e-05 0 3.9005e-05 0 4e-05 0 4.0005e-05 0 4.1e-05 0 4.1005e-05 0 4.2e-05 0 4.2005e-05 0 4.3e-05 0 4.3005e-05 0 4.4e-05 0 4.4005e-05 0 4.5e-05 0 4.5005e-05 0 4.6e-05 0 4.6005e-05 0 4.7e-05 0 4.7005e-05 0 4.8e-05 0 4.8005e-05 0 4.9e-05 0 4.9005e-05 0 5e-05 0 5.0005e-05 0 5.1e-05 0 5.1005e-05 0 5.2e-05 0 5.2005e-05 0 5.3e-05 0 5.3005e-05 0 5.4e-05 0 5.4005e-05 0 5.5e-05 0 5.5005e-05 0 5.6e-05 0 5.6005e-05 0 5.7e-05 0 5.7005e-05 0 5.8e-05 0 5.8005e-05 0 5.9e-05 0 5.9005e-05 0 6e-05 0 6.0005e-05 0 6.1e-05 0 6.1005e-05 0 6.2e-05 0 6.2005e-05 0 6.3e-05 0 6.3005e-05 0 6.4e-05 0 6.4005e-05 0 6.5e-05 0 6.5005e-05 0 6.6e-05 0 6.6005e-05 0 6.7e-05 0 6.7005e-05 0 6.8e-05 0 6.8005e-05 0 6.9e-05 0 6.9005e-05 0 7e-05 0 7.0005e-05 0 7.1e-05 0 7.1005e-05 0 7.2e-05 0 7.2005e-05 0 7.3e-05 0 7.3005e-05 0 7.4e-05 0 7.4005e-05 0 7.5e-05 0 7.5005e-05 0 7.6e-05 0 7.6005e-05 0 7.7e-05 0 7.7005e-05 0 7.8e-05 0 7.8005e-05 0 7.9e-05 0 7.9005e-05 0 8e-05 0 8.0005e-05 0 8.1e-05 0 8.1005e-05 0 8.2e-05 0 8.2005e-05 0 8.3e-05 0 8.3005e-05 0 8.4e-05 0 8.4005e-05 0 8.5e-05 0 8.5005e-05 0 8.6e-05 0 8.6005e-05 0 8.7e-05 0 8.7005e-05 0 8.8e-05 0 8.8005e-05 0 8.9e-05 0 8.9005e-05 0 9e-05 0 9.0005e-05 0 9.1e-05 0 9.1005e-05 0 9.2e-05 0 9.2005e-05 0 9.3e-05 0 9.3005e-05 0 9.4e-05 0 9.4005e-05 0 9.5e-05 0 9.5005e-05 0 9.6e-05 0 9.6005e-05 0 9.7e-05 0 9.7005e-05 0 9.8e-05 0 9.8005e-05 0 9.9e-05 0 9.9005e-05 0 0.0001 0 0.000100005 0 0.000101 0 0.000101005 0 0.000102 0 0.000102005 0 0.000103 0 0.000103005 0 0.000104 0 0.000104005 0 0.000105 0 0.000105005 0 0.000106 0 0.000106005 0 0.000107 0 0.000107005 0 0.000108 0 0.000108005 0 0.000109 0 0.000109005 0 0.00011 0 0.000110005 0 0.000111 0 0.000111005 0 0.000112 0 0.000112005 0 0.000113 0 0.000113005 0 0.000114 0 0.000114005 0 0.000115 0 0.000115005 0 0.000116 0 0.000116005 0 0.000117 0 0.000117005 0 0.000118 0 0.000118005 0 0.000119 0 0.000119005 0 0.00012 0 0.000120005 0 0.000121 0 0.000121005 0 0.000122 0 0.000122005 0 0.000123 0 0.000123005 0 0.000124 0 0.000124005 0 0.000125 0 0.000125005 0 0.000126 0 0.000126005 0 0.000127 0 0.000127005 0 0.000128 0 0.000128005 5 0.000129 5 0.000129005 5 0.00013 5 0.000130005 5 0.000131 5 0.000131005 5 0.000132 5 0.000132005 5 0.000133 5 0.000133005 5 0.000134 5 0.000134005 5 0.000135 5 0.000135005 5 0.000136 5 0.000136005 5 0.000137 5 0.000137005 5 0.000138 5 0.000138005 5 0.000139 5 0.000139005 5 0.00014 5 0.000140005 5 0.000141 5 0.000141005 5 0.000142 5 0.000142005 5 0.000143 5 0.000143005 5 0.000144 5 0.000144005 5 0.000145 5 0.000145005 5 0.000146 5 0.000146005 5 0.000147 5 0.000147005 5 0.000148 5 0.000148005 5 0.000149 5 0.000149005 5 0.00015 5 0.000150005 5 0.000151 5 0.000151005 5 0.000152 5 0.000152005 5 0.000153 5 0.000153005 5 0.000154 5 0.000154005 5 0.000155 5 0.000155005 5 0.000156 5 0.000156005 5 0.000157 5 0.000157005 5 0.000158 5 0.000158005 5 0.000159 5 0.000159005 5 0.00016 5 0.000160005 5 0.000161 5 0.000161005 5 0.000162 5 0.000162005 5 0.000163 5 0.000163005 5 0.000164 5 0.000164005 5 0.000165 5 0.000165005 5 0.000166 5 0.000166005 5 0.000167 5 0.000167005 5 0.000168 5 0.000168005 5 0.000169 5 0.000169005 5 0.00017 5 0.000170005 5 0.000171 5 0.000171005 5 0.000172 5 0.000172005 5 0.000173 5 0.000173005 5 0.000174 5 0.000174005 5 0.000175 5 0.000175005 5 0.000176 5 0.000176005 5 0.000177 5 0.000177005 5 0.000178 5 0.000178005 5 0.000179 5 0.000179005 5 0.00018 5 0.000180005 5 0.000181 5 0.000181005 5 0.000182 5 0.000182005 5 0.000183 5 0.000183005 5 0.000184 5 0.000184005 5 0.000185 5 0.000185005 5 0.000186 5 0.000186005 5 0.000187 5 0.000187005 5 0.000188 5 0.000188005 5 0.000189 5 0.000189005 5 0.00019 5 0.000190005 5 0.000191 5 0.000191005 5 0.000192 5 0.000192005 5 0.000193 5 0.000193005 5 0.000194 5 0.000194005 5 0.000195 5 0.000195005 5 0.000196 5 0.000196005 5 0.000197 5 0.000197005 5 0.000198 5 0.000198005 5 0.000199 5 0.000199005 5 0.0002 5 0.000200005 5 0.000201 5 0.000201005 5 0.000202 5 0.000202005 5 0.000203 5 0.000203005 5 0.000204 5 0.000204005 5 0.000205 5 0.000205005 5 0.000206 5 0.000206005 5 0.000207 5 0.000207005 5 0.000208 5 0.000208005 5 0.000209 5 0.000209005 5 0.00021 5 0.000210005 5 0.000211 5 0.000211005 5 0.000212 5 0.000212005 5 0.000213 5 0.000213005 5 0.000214 5 0.000214005 5 0.000215 5 0.000215005 5 0.000216 5 0.000216005 5 0.000217 5 0.000217005 5 0.000218 5 0.000218005 5 0.000219 5 0.000219005 5 0.00022 5 0.000220005 5 0.000221 5 0.000221005 5 0.000222 5 0.000222005 5 0.000223 5 0.000223005 5 0.000224 5 0.000224005 5 0.000225 5 0.000225005 5 0.000226 5 0.000226005 5 0.000227 5 0.000227005 5 0.000228 5 0.000228005 5 0.000229 5 0.000229005 5 0.00023 5 0.000230005 5 0.000231 5 0.000231005 5 0.000232 5 0.000232005 5 0.000233 5 0.000233005 5 0.000234 5 0.000234005 5 0.000235 5 0.000235005 5 0.000236 5 0.000236005 5 0.000237 5 0.000237005 5 0.000238 5 0.000238005 5 0.000239 5 0.000239005 5 0.00024 5 0.000240005 5 0.000241 5 0.000241005 5 0.000242 5 0.000242005 5 0.000243 5 0.000243005 5 0.000244 5 0.000244005 5 0.000245 5 0.000245005 5 0.000246 5 0.000246005 5 0.000247 5 0.000247005 5 0.000248 5 0.000248005 5 0.000249 5 0.000249005 5 0.00025 5 0.000250005 5 0.000251 5 0.000251005 5 0.000252 5 0.000252005 5 0.000253 5 0.000253005 5 0.000254 5 0.000254005 5 0.000255 5 0.000255005 5)
Vb2 b2 0 PWL(0 0 1e-06 0 1.005e-06 0 2e-06 0 2.005e-06 0 3e-06 0 3.005e-06 0 4e-06 0 4.005e-06 0 5e-06 0 5.005e-06 0 6e-06 0 6.005e-06 0 7e-06 0 7.005e-06 0 8e-06 0 8.005e-06 0 9e-06 0 9.005e-06 0 1e-05 0 1.0005e-05 0 1.1e-05 0 1.1005e-05 0 1.2e-05 0 1.2005e-05 0 1.3e-05 0 1.3005e-05 0 1.4e-05 0 1.4005e-05 0 1.5e-05 0 1.5005e-05 0 1.6e-05 0 1.6005e-05 0 1.7e-05 0 1.7005e-05 0 1.8e-05 0 1.8005e-05 0 1.9e-05 0 1.9005e-05 0 2e-05 0 2.0005e-05 0 2.1e-05 0 2.1005e-05 0 2.2e-05 0 2.2005e-05 0 2.3e-05 0 2.3005e-05 0 2.4e-05 0 2.4005e-05 0 2.5e-05 0 2.5005e-05 0 2.6e-05 0 2.6005e-05 0 2.7e-05 0 2.7005e-05 0 2.8e-05 0 2.8005e-05 0 2.9e-05 0 2.9005e-05 0 3e-05 0 3.0005e-05 0 3.1e-05 0 3.1005e-05 0 3.2e-05 0 3.2005e-05 0 3.3e-05 0 3.3005e-05 0 3.4e-05 0 3.4005e-05 0 3.5e-05 0 3.5005e-05 0 3.6e-05 0 3.6005e-05 0 3.7e-05 0 3.7005e-05 0 3.8e-05 0 3.8005e-05 0 3.9e-05 0 3.9005e-05 0 4e-05 0 4.0005e-05 0 4.1e-05 0 4.1005e-05 0 4.2e-05 0 4.2005e-05 0 4.3e-05 0 4.3005e-05 0 4.4e-05 0 4.4005e-05 0 4.5e-05 0 4.5005e-05 0 4.6e-05 0 4.6005e-05 0 4.7e-05 0 4.7005e-05 0 4.8e-05 0 4.8005e-05 0 4.9e-05 0 4.9005e-05 0 5e-05 0 5.0005e-05 0 5.1e-05 0 5.1005e-05 0 5.2e-05 0 5.2005e-05 0 5.3e-05 0 5.3005e-05 0 5.4e-05 0 5.4005e-05 0 5.5e-05 0 5.5005e-05 0 5.6e-05 0 5.6005e-05 0 5.7e-05 0 5.7005e-05 0 5.8e-05 0 5.8005e-05 0 5.9e-05 0 5.9005e-05 0 6e-05 0 6.0005e-05 0 6.1e-05 0 6.1005e-05 0 6.2e-05 0 6.2005e-05 0 6.3e-05 0 6.3005e-05 0 6.4e-05 0 6.4005e-05 5 6.5e-05 5 6.5005e-05 5 6.6e-05 5 6.6005e-05 5 6.7e-05 5 6.7005e-05 5 6.8e-05 5 6.8005e-05 5 6.9e-05 5 6.9005e-05 5 7e-05 5 7.0005e-05 5 7.1e-05 5 7.1005e-05 5 7.2e-05 5 7.2005e-05 5 7.3e-05 5 7.3005e-05 5 7.4e-05 5 7.4005e-05 5 7.5e-05 5 7.5005e-05 5 7.6e-05 5 7.6005e-05 5 7.7e-05 5 7.7005e-05 5 7.8e-05 5 7.8005e-05 5 7.9e-05 5 7.9005e-05 5 8e-05 5 8.0005e-05 5 8.1e-05 5 8.1005e-05 5 8.2e-05 5 8.2005e-05 5 8.3e-05 5 8.3005e-05 5 8.4e-05 5 8.4005e-05 5 8.5e-05 5 8.5005e-05 5 8.6e-05 5 8.6005e-05 5 8.7e-05 5 8.7005e-05 5 8.8e-05 5 8.8005e-05 5 8.9e-05 5 8.9005e-05 5 9e-05 5 9.0005e-05 5 9.1e-05 5 9.1005e-05 5 9.2e-05 5 9.2005e-05 5 9.3e-05 5 9.3005e-05 5 9.4e-05 5 9.4005e-05 5 9.5e-05 5 9.5005e-05 5 9.6e-05 5 9.6005e-05 5 9.7e-05 5 9.7005e-05 5 9.8e-05 5 9.8005e-05 5 9.9e-05 5 9.9005e-05 5 0.0001 5 0.000100005 5 0.000101 5 0.000101005 5 0.000102 5 0.000102005 5 0.000103 5 0.000103005 5 0.000104 5 0.000104005 5 0.000105 5 0.000105005 5 0.000106 5 0.000106005 5 0.000107 5 0.000107005 5 0.000108 5 0.000108005 5 0.000109 5 0.000109005 5 0.00011 5 0.000110005 5 0.000111 5 0.000111005 5 0.000112 5 0.000112005 5 0.000113 5 0.000113005 5 0.000114 5 0.000114005 5 0.000115 5 0.000115005 5 0.000116 5 0.000116005 5 0.000117 5 0.000117005 5 0.000118 5 0.000118005 5 0.000119 5 0.000119005 5 0.00012 5 0.000120005 5 0.000121 5 0.000121005 5 0.000122 5 0.000122005 5 0.000123 5 0.000123005 5 0.000124 5 0.000124005 5 0.000125 5 0.000125005 5 0.000126 5 0.000126005 5 0.000127 5 0.000127005 5 0.000128 5 0.000128005 0 0.000129 0 0.000129005 0 0.00013 0 0.000130005 0 0.000131 0 0.000131005 0 0.000132 0 0.000132005 0 0.000133 0 0.000133005 0 0.000134 0 0.000134005 0 0.000135 0 0.000135005 0 0.000136 0 0.000136005 0 0.000137 0 0.000137005 0 0.000138 0 0.000138005 0 0.000139 0 0.000139005 0 0.00014 0 0.000140005 0 0.000141 0 0.000141005 0 0.000142 0 0.000142005 0 0.000143 0 0.000143005 0 0.000144 0 0.000144005 0 0.000145 0 0.000145005 0 0.000146 0 0.000146005 0 0.000147 0 0.000147005 0 0.000148 0 0.000148005 0 0.000149 0 0.000149005 0 0.00015 0 0.000150005 0 0.000151 0 0.000151005 0 0.000152 0 0.000152005 0 0.000153 0 0.000153005 0 0.000154 0 0.000154005 0 0.000155 0 0.000155005 0 0.000156 0 0.000156005 0 0.000157 0 0.000157005 0 0.000158 0 0.000158005 0 0.000159 0 0.000159005 0 0.00016 0 0.000160005 0 0.000161 0 0.000161005 0 0.000162 0 0.000162005 0 0.000163 0 0.000163005 0 0.000164 0 0.000164005 0 0.000165 0 0.000165005 0 0.000166 0 0.000166005 0 0.000167 0 0.000167005 0 0.000168 0 0.000168005 0 0.000169 0 0.000169005 0 0.00017 0 0.000170005 0 0.000171 0 0.000171005 0 0.000172 0 0.000172005 0 0.000173 0 0.000173005 0 0.000174 0 0.000174005 0 0.000175 0 0.000175005 0 0.000176 0 0.000176005 0 0.000177 0 0.000177005 0 0.000178 0 0.000178005 0 0.000179 0 0.000179005 0 0.00018 0 0.000180005 0 0.000181 0 0.000181005 0 0.000182 0 0.000182005 0 0.000183 0 0.000183005 0 0.000184 0 0.000184005 0 0.000185 0 0.000185005 0 0.000186 0 0.000186005 0 0.000187 0 0.000187005 0 0.000188 0 0.000188005 0 0.000189 0 0.000189005 0 0.00019 0 0.000190005 0 0.000191 0 0.000191005 0 0.000192 0 0.000192005 5 0.000193 5 0.000193005 5 0.000194 5 0.000194005 5 0.000195 5 0.000195005 5 0.000196 5 0.000196005 5 0.000197 5 0.000197005 5 0.000198 5 0.000198005 5 0.000199 5 0.000199005 5 0.0002 5 0.000200005 5 0.000201 5 0.000201005 5 0.000202 5 0.000202005 5 0.000203 5 0.000203005 5 0.000204 5 0.000204005 5 0.000205 5 0.000205005 5 0.000206 5 0.000206005 5 0.000207 5 0.000207005 5 0.000208 5 0.000208005 5 0.000209 5 0.000209005 5 0.00021 5 0.000210005 5 0.000211 5 0.000211005 5 0.000212 5 0.000212005 5 0.000213 5 0.000213005 5 0.000214 5 0.000214005 5 0.000215 5 0.000215005 5 0.000216 5 0.000216005 5 0.000217 5 0.000217005 5 0.000218 5 0.000218005 5 0.000219 5 0.000219005 5 0.00022 5 0.000220005 5 0.000221 5 0.000221005 5 0.000222 5 0.000222005 5 0.000223 5 0.000223005 5 0.000224 5 0.000224005 5 0.000225 5 0.000225005 5 0.000226 5 0.000226005 5 0.000227 5 0.000227005 5 0.000228 5 0.000228005 5 0.000229 5 0.000229005 5 0.00023 5 0.000230005 5 0.000231 5 0.000231005 5 0.000232 5 0.000232005 5 0.000233 5 0.000233005 5 0.000234 5 0.000234005 5 0.000235 5 0.000235005 5 0.000236 5 0.000236005 5 0.000237 5 0.000237005 5 0.000238 5 0.000238005 5 0.000239 5 0.000239005 5 0.00024 5 0.000240005 5 0.000241 5 0.000241005 5 0.000242 5 0.000242005 5 0.000243 5 0.000243005 5 0.000244 5 0.000244005 5 0.000245 5 0.000245005 5 0.000246 5 0.000246005 5 0.000247 5 0.000247005 5 0.000248 5 0.000248005 5 0.000249 5 0.000249005 5 0.00025 5 0.000250005 5 0.000251 5 0.000251005 5 0.000252 5 0.000252005 5 0.000253 5 0.000253005 5 0.000254 5 0.000254005 5 0.000255 5 0.000255005 5)
Vb3 b3 0 PWL(0 0 1e-06 0 1.005e-06 0 2e-06 0 2.005e-06 0 3e-06 0 3.005e-06 0 4e-06 0 4.005e-06 0 5e-06 0 5.005e-06 0 6e-06 0 6.005e-06 0 7e-06 0 7.005e-06 0 8e-06 0 8.005e-06 0 9e-06 0 9.005e-06 0 1e-05 0 1.0005e-05 0 1.1e-05 0 1.1005e-05 0 1.2e-05 0 1.2005e-05 0 1.3e-05 0 1.3005e-05 0 1.4e-05 0 1.4005e-05 0 1.5e-05 0 1.5005e-05 0 1.6e-05 0 1.6005e-05 0 1.7e-05 0 1.7005e-05 0 1.8e-05 0 1.8005e-05 0 1.9e-05 0 1.9005e-05 0 2e-05 0 2.0005e-05 0 2.1e-05 0 2.1005e-05 0 2.2e-05 0 2.2005e-05 0 2.3e-05 0 2.3005e-05 0 2.4e-05 0 2.4005e-05 0 2.5e-05 0 2.5005e-05 0 2.6e-05 0 2.6005e-05 0 2.7e-05 0 2.7005e-05 0 2.8e-05 0 2.8005e-05 0 2.9e-05 0 2.9005e-05 0 3e-05 0 3.0005e-05 0 3.1e-05 0 3.1005e-05 0 3.2e-05 0 3.2005e-05 5 3.3e-05 5 3.3005e-05 5 3.4e-05 5 3.4005e-05 5 3.5e-05 5 3.5005e-05 5 3.6e-05 5 3.6005e-05 5 3.7e-05 5 3.7005e-05 5 3.8e-05 5 3.8005e-05 5 3.9e-05 5 3.9005e-05 5 4e-05 5 4.0005e-05 5 4.1e-05 5 4.1005e-05 5 4.2e-05 5 4.2005e-05 5 4.3e-05 5 4.3005e-05 5 4.4e-05 5 4.4005e-05 5 4.5e-05 5 4.5005e-05 5 4.6e-05 5 4.6005e-05 5 4.7e-05 5 4.7005e-05 5 4.8e-05 5 4.8005e-05 5 4.9e-05 5 4.9005e-05 5 5e-05 5 5.0005e-05 5 5.1e-05 5 5.1005e-05 5 5.2e-05 5 5.2005e-05 5 5.3e-05 5 5.3005e-05 5 5.4e-05 5 5.4005e-05 5 5.5e-05 5 5.5005e-05 5 5.6e-05 5 5.6005e-05 5 5.7e-05 5 5.7005e-05 5 5.8e-05 5 5.8005e-05 5 5.9e-05 5 5.9005e-05 5 6e-05 5 6.0005e-05 5 6.1e-05 5 6.1005e-05 5 6.2e-05 5 6.2005e-05 5 6.3e-05 5 6.3005e-05 5 6.4e-05 5 6.4005e-05 0 6.5e-05 0 6.5005e-05 0 6.6e-05 0 6.6005e-05 0 6.7e-05 0 6.7005e-05 0 6.8e-05 0 6.8005e-05 0 6.9e-05 0 6.9005e-05 0 7e-05 0 7.0005e-05 0 7.1e-05 0 7.1005e-05 0 7.2e-05 0 7.2005e-05 0 7.3e-05 0 7.3005e-05 0 7.4e-05 0 7.4005e-05 0 7.5e-05 0 7.5005e-05 0 7.6e-05 0 7.6005e-05 0 7.7e-05 0 7.7005e-05 0 7.8e-05 0 7.8005e-05 0 7.9e-05 0 7.9005e-05 0 8e-05 0 8.0005e-05 0 8.1e-05 0 8.1005e-05 0 8.2e-05 0 8.2005e-05 0 8.3e-05 0 8.3005e-05 0 8.4e-05 0 8.4005e-05 0 8.5e-05 0 8.5005e-05 0 8.6e-05 0 8.6005e-05 0 8.7e-05 0 8.7005e-05 0 8.8e-05 0 8.8005e-05 0 8.9e-05 0 8.9005e-05 0 9e-05 0 9.0005e-05 0 9.1e-05 0 9.1005e-05 0 9.2e-05 0 9.2005e-05 0 9.3e-05 0 9.3005e-05 0 9.4e-05 0 9.4005e-05 0 9.5e-05 0 9.5005e-05 0 9.6e-05 0 9.6005e-05 5 9.7e-05 5 9.7005e-05 5 9.8e-05 5 9.8005e-05 5 9.9e-05 5 9.9005e-05 5 0.0001 5 0.000100005 5 0.000101 5 0.000101005 5 0.000102 5 0.000102005 5 0.000103 5 0.000103005 5 0.000104 5 0.000104005 5 0.000105 5 0.000105005 5 0.000106 5 0.000106005 5 0.000107 5 0.000107005 5 0.000108 5 0.000108005 5 0.000109 5 0.000109005 5 0.00011 5 0.000110005 5 0.000111 5 0.000111005 5 0.000112 5 0.000112005 5 0.000113 5 0.000113005 5 0.000114 5 0.000114005 5 0.000115 5 0.000115005 5 0.000116 5 0.000116005 5 0.000117 5 0.000117005 5 0.000118 5 0.000118005 5 0.000119 5 0.000119005 5 0.00012 5 0.000120005 5 0.000121 5 0.000121005 5 0.000122 5 0.000122005 5 0.000123 5 0.000123005 5 0.000124 5 0.000124005 5 0.000125 5 0.000125005 5 0.000126 5 0.000126005 5 0.000127 5 0.000127005 5 0.000128 5 0.000128005 0 0.000129 0 0.000129005 0 0.00013 0 0.000130005 0 0.000131 0 0.000131005 0 0.000132 0 0.000132005 0 0.000133 0 0.000133005 0 0.000134 0 0.000134005 0 0.000135 0 0.000135005 0 0.000136 0 0.000136005 0 0.000137 0 0.000137005 0 0.000138 0 0.000138005 0 0.000139 0 0.000139005 0 0.00014 0 0.000140005 0 0.000141 0 0.000141005 0 0.000142 0 0.000142005 0 0.000143 0 0.000143005 0 0.000144 0 0.000144005 0 0.000145 0 0.000145005 0 0.000146 0 0.000146005 0 0.000147 0 0.000147005 0 0.000148 0 0.000148005 0 0.000149 0 0.000149005 0 0.00015 0 0.000150005 0 0.000151 0 0.000151005 0 0.000152 0 0.000152005 0 0.000153 0 0.000153005 0 0.000154 0 0.000154005 0 0.000155 0 0.000155005 0 0.000156 0 0.000156005 0 0.000157 0 0.000157005 0 0.000158 0 0.000158005 0 0.000159 0 0.000159005 0 0.00016 0 0.000160005 5 0.000161 5 0.000161005 5 0.000162 5 0.000162005 5 0.000163 5 0.000163005 5 0.000164 5 0.000164005 5 0.000165 5 0.000165005 5 0.000166 5 0.000166005 5 0.000167 5 0.000167005 5 0.000168 5 0.000168005 5 0.000169 5 0.000169005 5 0.00017 5 0.000170005 5 0.000171 5 0.000171005 5 0.000172 5 0.000172005 5 0.000173 5 0.000173005 5 0.000174 5 0.000174005 5 0.000175 5 0.000175005 5 0.000176 5 0.000176005 5 0.000177 5 0.000177005 5 0.000178 5 0.000178005 5 0.000179 5 0.000179005 5 0.00018 5 0.000180005 5 0.000181 5 0.000181005 5 0.000182 5 0.000182005 5 0.000183 5 0.000183005 5 0.000184 5 0.000184005 5 0.000185 5 0.000185005 5 0.000186 5 0.000186005 5 0.000187 5 0.000187005 5 0.000188 5 0.000188005 5 0.000189 5 0.000189005 5 0.00019 5 0.000190005 5 0.000191 5 0.000191005 5 0.000192 5 0.000192005 0 0.000193 0 0.000193005 0 0.000194 0 0.000194005 0 0.000195 0 0.000195005 0 0.000196 0 0.000196005 0 0.000197 0 0.000197005 0 0.000198 0 0.000198005 0 0.000199 0 0.000199005 0 0.0002 0 0.000200005 0 0.000201 0 0.000201005 0 0.000202 0 0.000202005 0 0.000203 0 0.000203005 0 0.000204 0 0.000204005 0 0.000205 0 0.000205005 0 0.000206 0 0.000206005 0 0.000207 0 0.000207005 0 0.000208 0 0.000208005 0 0.000209 0 0.000209005 0 0.00021 0 0.000210005 0 0.000211 0 0.000211005 0 0.000212 0 0.000212005 0 0.000213 0 0.000213005 0 0.000214 0 0.000214005 0 0.000215 0 0.000215005 0 0.000216 0 0.000216005 0 0.000217 0 0.000217005 0 0.000218 0 0.000218005 0 0.000219 0 0.000219005 0 0.00022 0 0.000220005 0 0.000221 0 0.000221005 0 0.000222 0 0.000222005 0 0.000223 0 0.000223005 0 0.000224 0 0.000224005 5 0.000225 5 0.000225005 5 0.000226 5 0.000226005 5 0.000227 5 0.000227005 5 0.000228 5 0.000228005 5 0.000229 5 0.000229005 5 0.00023 5 0.000230005 5 0.000231 5 0.000231005 5 0.000232 5 0.000232005 5 0.000233 5 0.000233005 5 0.000234 5 0.000234005 5 0.000235 5 0.000235005 5 0.000236 5 0.000236005 5 0.000237 5 0.000237005 5 0.000238 5 0.000238005 5 0.000239 5 0.000239005 5 0.00024 5 0.000240005 5 0.000241 5 0.000241005 5 0.000242 5 0.000242005 5 0.000243 5 0.000243005 5 0.000244 5 0.000244005 5 0.000245 5 0.000245005 5 0.000246 5 0.000246005 5 0.000247 5 0.000247005 5 0.000248 5 0.000248005 5 0.000249 5 0.000249005 5 0.00025 5 0.000250005 5 0.000251 5 0.000251005 5 0.000252 5 0.000252005 5 0.000253 5 0.000253005 5 0.000254 5 0.000254005 5 0.000255 5 0.000255005 5)
Vb4 b4 0 PWL(0 0 1e-06 0 1.005e-06 0 2e-06 0 2.005e-06 0 3e-06 0 3.005e-06 0 4e-06 0 4.005e-06 0 5e-06 0 5.005e-06 0 6e-06 0 6.005e-06 0 7e-06 0 7.005e-06 0 8e-06 0 8.005e-06 0 9e-06 0 9.005e-06 0 1e-05 0 1.0005e-05 0 1.1e-05 0 1.1005e-05 0 1.2e-05 0 1.2005e-05 0 1.3e-05 0 1.3005e-05 0 1.4e-05 0 1.4005e-05 0 1.5e-05 0 1.5005e-05 0 1.6e-05 0 1.6005e-05 5 1.7e-05 5 1.7005e-05 5 1.8e-05 5 1.8005e-05 5 1.9e-05 5 1.9005e-05 5 2e-05 5 2.0005e-05 5 2.1e-05 5 2.1005e-05 5 2.2e-05 5 2.2005e-05 5 2.3e-05 5 2.3005e-05 5 2.4e-05 5 2.4005e-05 5 2.5e-05 5 2.5005e-05 5 2.6e-05 5 2.6005e-05 5 2.7e-05 5 2.7005e-05 5 2.8e-05 5 2.8005e-05 5 2.9e-05 5 2.9005e-05 5 3e-05 5 3.0005e-05 5 3.1e-05 5 3.1005e-05 5 3.2e-05 5 3.2005e-05 0 3.3e-05 0 3.3005e-05 0 3.4e-05 0 3.4005e-05 0 3.5e-05 0 3.5005e-05 0 3.6e-05 0 3.6005e-05 0 3.7e-05 0 3.7005e-05 0 3.8e-05 0 3.8005e-05 0 3.9e-05 0 3.9005e-05 0 4e-05 0 4.0005e-05 0 4.1e-05 0 4.1005e-05 0 4.2e-05 0 4.2005e-05 0 4.3e-05 0 4.3005e-05 0 4.4e-05 0 4.4005e-05 0 4.5e-05 0 4.5005e-05 0 4.6e-05 0 4.6005e-05 0 4.7e-05 0 4.7005e-05 0 4.8e-05 0 4.8005e-05 5 4.9e-05 5 4.9005e-05 5 5e-05 5 5.0005e-05 5 5.1e-05 5 5.1005e-05 5 5.2e-05 5 5.2005e-05 5 5.3e-05 5 5.3005e-05 5 5.4e-05 5 5.4005e-05 5 5.5e-05 5 5.5005e-05 5 5.6e-05 5 5.6005e-05 5 5.7e-05 5 5.7005e-05 5 5.8e-05 5 5.8005e-05 5 5.9e-05 5 5.9005e-05 5 6e-05 5 6.0005e-05 5 6.1e-05 5 6.1005e-05 5 6.2e-05 5 6.2005e-05 5 6.3e-05 5 6.3005e-05 5 6.4e-05 5 6.4005e-05 0 6.5e-05 0 6.5005e-05 0 6.6e-05 0 6.6005e-05 0 6.7e-05 0 6.7005e-05 0 6.8e-05 0 6.8005e-05 0 6.9e-05 0 6.9005e-05 0 7e-05 0 7.0005e-05 0 7.1e-05 0 7.1005e-05 0 7.2e-05 0 7.2005e-05 0 7.3e-05 0 7.3005e-05 0 7.4e-05 0 7.4005e-05 0 7.5e-05 0 7.5005e-05 0 7.6e-05 0 7.6005e-05 0 7.7e-05 0 7.7005e-05 0 7.8e-05 0 7.8005e-05 0 7.9e-05 0 7.9005e-05 0 8e-05 0 8.0005e-05 5 8.1e-05 5 8.1005e-05 5 8.2e-05 5 8.2005e-05 5 8.3e-05 5 8.3005e-05 5 8.4e-05 5 8.4005e-05 5 8.5e-05 5 8.5005e-05 5 8.6e-05 5 8.6005e-05 5 8.7e-05 5 8.7005e-05 5 8.8e-05 5 8.8005e-05 5 8.9e-05 5 8.9005e-05 5 9e-05 5 9.0005e-05 5 9.1e-05 5 9.1005e-05 5 9.2e-05 5 9.2005e-05 5 9.3e-05 5 9.3005e-05 5 9.4e-05 5 9.4005e-05 5 9.5e-05 5 9.5005e-05 5 9.6e-05 5 9.6005e-05 0 9.7e-05 0 9.7005e-05 0 9.8e-05 0 9.8005e-05 0 9.9e-05 0 9.9005e-05 0 0.0001 0 0.000100005 0 0.000101 0 0.000101005 0 0.000102 0 0.000102005 0 0.000103 0 0.000103005 0 0.000104 0 0.000104005 0 0.000105 0 0.000105005 0 0.000106 0 0.000106005 0 0.000107 0 0.000107005 0 0.000108 0 0.000108005 0 0.000109 0 0.000109005 0 0.00011 0 0.000110005 0 0.000111 0 0.000111005 0 0.000112 0 0.000112005 5 0.000113 5 0.000113005 5 0.000114 5 0.000114005 5 0.000115 5 0.000115005 5 0.000116 5 0.000116005 5 0.000117 5 0.000117005 5 0.000118 5 0.000118005 5 0.000119 5 0.000119005 5 0.00012 5 0.000120005 5 0.000121 5 0.000121005 5 0.000122 5 0.000122005 5 0.000123 5 0.000123005 5 0.000124 5 0.000124005 5 0.000125 5 0.000125005 5 0.000126 5 0.000126005 5 0.000127 5 0.000127005 5 0.000128 5 0.000128005 0 0.000129 0 0.000129005 0 0.00013 0 0.000130005 0 0.000131 0 0.000131005 0 0.000132 0 0.000132005 0 0.000133 0 0.000133005 0 0.000134 0 0.000134005 0 0.000135 0 0.000135005 0 0.000136 0 0.000136005 0 0.000137 0 0.000137005 0 0.000138 0 0.000138005 0 0.000139 0 0.000139005 0 0.00014 0 0.000140005 0 0.000141 0 0.000141005 0 0.000142 0 0.000142005 0 0.000143 0 0.000143005 0 0.000144 0 0.000144005 5 0.000145 5 0.000145005 5 0.000146 5 0.000146005 5 0.000147 5 0.000147005 5 0.000148 5 0.000148005 5 0.000149 5 0.000149005 5 0.00015 5 0.000150005 5 0.000151 5 0.000151005 5 0.000152 5 0.000152005 5 0.000153 5 0.000153005 5 0.000154 5 0.000154005 5 0.000155 5 0.000155005 5 0.000156 5 0.000156005 5 0.000157 5 0.000157005 5 0.000158 5 0.000158005 5 0.000159 5 0.000159005 5 0.00016 5 0.000160005 0 0.000161 0 0.000161005 0 0.000162 0 0.000162005 0 0.000163 0 0.000163005 0 0.000164 0 0.000164005 0 0.000165 0 0.000165005 0 0.000166 0 0.000166005 0 0.000167 0 0.000167005 0 0.000168 0 0.000168005 0 0.000169 0 0.000169005 0 0.00017 0 0.000170005 0 0.000171 0 0.000171005 0 0.000172 0 0.000172005 0 0.000173 0 0.000173005 0 0.000174 0 0.000174005 0 0.000175 0 0.000175005 0 0.000176 0 0.000176005 5 0.000177 5 0.000177005 5 0.000178 5 0.000178005 5 0.000179 5 0.000179005 5 0.00018 5 0.000180005 5 0.000181 5 0.000181005 5 0.000182 5 0.000182005 5 0.000183 5 0.000183005 5 0.000184 5 0.000184005 5 0.000185 5 0.000185005 5 0.000186 5 0.000186005 5 0.000187 5 0.000187005 5 0.000188 5 0.000188005 5 0.000189 5 0.000189005 5 0.00019 5 0.000190005 5 0.000191 5 0.000191005 5 0.000192 5 0.000192005 0 0.000193 0 0.000193005 0 0.000194 0 0.000194005 0 0.000195 0 0.000195005 0 0.000196 0 0.000196005 0 0.000197 0 0.000197005 0 0.000198 0 0.000198005 0 0.000199 0 0.000199005 0 0.0002 0 0.000200005 0 0.000201 0 0.000201005 0 0.000202 0 0.000202005 0 0.000203 0 0.000203005 0 0.000204 0 0.000204005 0 0.000205 0 0.000205005 0 0.000206 0 0.000206005 0 0.000207 0 0.000207005 0 0.000208 0 0.000208005 5 0.000209 5 0.000209005 5 0.00021 5 0.000210005 5 0.000211 5 0.000211005 5 0.000212 5 0.000212005 5 0.000213 5 0.000213005 5 0.000214 5 0.000214005 5 0.000215 5 0.000215005 5 0.000216 5 0.000216005 5 0.000217 5 0.000217005 5 0.000218 5 0.000218005 5 0.000219 5 0.000219005 5 0.00022 5 0.000220005 5 0.000221 5 0.000221005 5 0.000222 5 0.000222005 5 0.000223 5 0.000223005 5 0.000224 5 0.000224005 0 0.000225 0 0.000225005 0 0.000226 0 0.000226005 0 0.000227 0 0.000227005 0 0.000228 0 0.000228005 0 0.000229 0 0.000229005 0 0.00023 0 0.000230005 0 0.000231 0 0.000231005 0 0.000232 0 0.000232005 0 0.000233 0 0.000233005 0 0.000234 0 0.000234005 0 0.000235 0 0.000235005 0 0.000236 0 0.000236005 0 0.000237 0 0.000237005 0 0.000238 0 0.000238005 0 0.000239 0 0.000239005 0 0.00024 0 0.000240005 5 0.000241 5 0.000241005 5 0.000242 5 0.000242005 5 0.000243 5 0.000243005 5 0.000244 5 0.000244005 5 0.000245 5 0.000245005 5 0.000246 5 0.000246005 5 0.000247 5 0.000247005 5 0.000248 5 0.000248005 5 0.000249 5 0.000249005 5 0.00025 5 0.000250005 5 0.000251 5 0.000251005 5 0.000252 5 0.000252005 5 0.000253 5 0.000253005 5 0.000254 5 0.000254005 5 0.000255 5 0.000255005 5)
Vb5 b5 0 PWL(0 0 1e-06 0 1.005e-06 0 2e-06 0 2.005e-06 0 3e-06 0 3.005e-06 0 4e-06 0 4.005e-06 0 5e-06 0 5.005e-06 0 6e-06 0 6.005e-06 0 7e-06 0 7.005e-06 0 8e-06 0 8.005e-06 5 9e-06 5 9.005e-06 5 1e-05 5 1.0005e-05 5 1.1e-05 5 1.1005e-05 5 1.2e-05 5 1.2005e-05 5 1.3e-05 5 1.3005e-05 5 1.4e-05 5 1.4005e-05 5 1.5e-05 5 1.5005e-05 5 1.6e-05 5 1.6005e-05 0 1.7e-05 0 1.7005e-05 0 1.8e-05 0 1.8005e-05 0 1.9e-05 0 1.9005e-05 0 2e-05 0 2.0005e-05 0 2.1e-05 0 2.1005e-05 0 2.2e-05 0 2.2005e-05 0 2.3e-05 0 2.3005e-05 0 2.4e-05 0 2.4005e-05 5 2.5e-05 5 2.5005e-05 5 2.6e-05 5 2.6005e-05 5 2.7e-05 5 2.7005e-05 5 2.8e-05 5 2.8005e-05 5 2.9e-05 5 2.9005e-05 5 3e-05 5 3.0005e-05 5 3.1e-05 5 3.1005e-05 5 3.2e-05 5 3.2005e-05 0 3.3e-05 0 3.3005e-05 0 3.4e-05 0 3.4005e-05 0 3.5e-05 0 3.5005e-05 0 3.6e-05 0 3.6005e-05 0 3.7e-05 0 3.7005e-05 0 3.8e-05 0 3.8005e-05 0 3.9e-05 0 3.9005e-05 0 4e-05 0 4.0005e-05 5 4.1e-05 5 4.1005e-05 5 4.2e-05 5 4.2005e-05 5 4.3e-05 5 4.3005e-05 5 4.4e-05 5 4.4005e-05 5 4.5e-05 5 4.5005e-05 5 4.6e-05 5 4.6005e-05 5 4.7e-05 5 4.7005e-05 5 4.8e-05 5 4.8005e-05 0 4.9e-05 0 4.9005e-05 0 5e-05 0 5.0005e-05 0 5.1e-05 0 5.1005e-05 0 5.2e-05 0 5.2005e-05 0 5.3e-05 0 5.3005e-05 0 5.4e-05 0 5.4005e-05 0 5.5e-05 0 5.5005e-05 0 5.6e-05 0 5.6005e-05 5 5.7e-05 5 5.7005e-05 5 5.8e-05 5 5.8005e-05 5 5.9e-05 5 5.9005e-05 5 6e-05 5 6.0005e-05 5 6.1e-05 5 6.1005e-05 5 6.2e-05 5 6.2005e-05 5 6.3e-05 5 6.3005e-05 5 6.4e-05 5 6.4005e-05 0 6.5e-05 0 6.5005e-05 0 6.6e-05 0 6.6005e-05 0 6.7e-05 0 6.7005e-05 0 6.8e-05 0 6.8005e-05 0 6.9e-05 0 6.9005e-05 0 7e-05 0 7.0005e-05 0 7.1e-05 0 7.1005e-05 0 7.2e-05 0 7.2005e-05 5 7.3e-05 5 7.3005e-05 5 7.4e-05 5 7.4005e-05 5 7.5e-05 5 7.5005e-05 5 7.6e-05 5 7.6005e-05 5 7.7e-05 5 7.7005e-05 5 7.8e-05 5 7.8005e-05 5 7.9e-05 5 7.9005e-05 5 8e-05 5 8.0005e-05 0 8.1e-05 0 8.1005e-05 0 8.2e-05 0 8.2005e-05 0 8.3e-05 0 8.3005e-05 0 8.4e-05 0 8.4005e-05 0 8.5e-05 0 8.5005e-05 0 8.6e-05 0 8.6005e-05 0 8.7e-05 0 8.7005e-05 0 8.8e-05 0 8.8005e-05 5 8.9e-05 5 8.9005e-05 5 9e-05 5 9.0005e-05 5 9.1e-05 5 9.1005e-05 5 9.2e-05 5 9.2005e-05 5 9.3e-05 5 9.3005e-05 5 9.4e-05 5 9.4005e-05 5 9.5e-05 5 9.5005e-05 5 9.6e-05 5 9.6005e-05 0 9.7e-05 0 9.7005e-05 0 9.8e-05 0 9.8005e-05 0 9.9e-05 0 9.9005e-05 0 0.0001 0 0.000100005 0 0.000101 0 0.000101005 0 0.000102 0 0.000102005 0 0.000103 0 0.000103005 0 0.000104 0 0.000104005 5 0.000105 5 0.000105005 5 0.000106 5 0.000106005 5 0.000107 5 0.000107005 5 0.000108 5 0.000108005 5 0.000109 5 0.000109005 5 0.00011 5 0.000110005 5 0.000111 5 0.000111005 5 0.000112 5 0.000112005 0 0.000113 0 0.000113005 0 0.000114 0 0.000114005 0 0.000115 0 0.000115005 0 0.000116 0 0.000116005 0 0.000117 0 0.000117005 0 0.000118 0 0.000118005 0 0.000119 0 0.000119005 0 0.00012 0 0.000120005 5 0.000121 5 0.000121005 5 0.000122 5 0.000122005 5 0.000123 5 0.000123005 5 0.000124 5 0.000124005 5 0.000125 5 0.000125005 5 0.000126 5 0.000126005 5 0.000127 5 0.000127005 5 0.000128 5 0.000128005 0 0.000129 0 0.000129005 0 0.00013 0 0.000130005 0 0.000131 0 0.000131005 0 0.000132 0 0.000132005 0 0.000133 0 0.000133005 0 0.000134 0 0.000134005 0 0.000135 0 0.000135005 0 0.000136 0 0.000136005 5 0.000137 5 0.000137005 5 0.000138 5 0.000138005 5 0.000139 5 0.000139005 5 0.00014 5 0.000140005 5 0.000141 5 0.000141005 5 0.000142 5 0.000142005 5 0.000143 5 0.000143005 5 0.000144 5 0.000144005 0 0.000145 0 0.000145005 0 0.000146 0 0.000146005 0 0.000147 0 0.000147005 0 0.000148 0 0.000148005 0 0.000149 0 0.000149005 0 0.00015 0 0.000150005 0 0.000151 0 0.000151005 0 0.000152 0 0.000152005 5 0.000153 5 0.000153005 5 0.000154 5 0.000154005 5 0.000155 5 0.000155005 5 0.000156 5 0.000156005 5 0.000157 5 0.000157005 5 0.000158 5 0.000158005 5 0.000159 5 0.000159005 5 0.00016 5 0.000160005 0 0.000161 0 0.000161005 0 0.000162 0 0.000162005 0 0.000163 0 0.000163005 0 0.000164 0 0.000164005 0 0.000165 0 0.000165005 0 0.000166 0 0.000166005 0 0.000167 0 0.000167005 0 0.000168 0 0.000168005 5 0.000169 5 0.000169005 5 0.00017 5 0.000170005 5 0.000171 5 0.000171005 5 0.000172 5 0.000172005 5 0.000173 5 0.000173005 5 0.000174 5 0.000174005 5 0.000175 5 0.000175005 5 0.000176 5 0.000176005 0 0.000177 0 0.000177005 0 0.000178 0 0.000178005 0 0.000179 0 0.000179005 0 0.00018 0 0.000180005 0 0.000181 0 0.000181005 0 0.000182 0 0.000182005 0 0.000183 0 0.000183005 0 0.000184 0 0.000184005 5 0.000185 5 0.000185005 5 0.000186 5 0.000186005 5 0.000187 5 0.000187005 5 0.000188 5 0.000188005 5 0.000189 5 0.000189005 5 0.00019 5 0.000190005 5 0.000191 5 0.000191005 5 0.000192 5 0.000192005 0 0.000193 0 0.000193005 0 0.000194 0 0.000194005 0 0.000195 0 0.000195005 0 0.000196 0 0.000196005 0 0.000197 0 0.000197005 0 0.000198 0 0.000198005 0 0.000199 0 0.000199005 0 0.0002 0 0.000200005 5 0.000201 5 0.000201005 5 0.000202 5 0.000202005 5 0.000203 5 0.000203005 5 0.000204 5 0.000204005 5 0.000205 5 0.000205005 5 0.000206 5 0.000206005 5 0.000207 5 0.000207005 5 0.000208 5 0.000208005 0 0.000209 0 0.000209005 0 0.00021 0 0.000210005 0 0.000211 0 0.000211005 0 0.000212 0 0.000212005 0 0.000213 0 0.000213005 0 0.000214 0 0.000214005 0 0.000215 0 0.000215005 0 0.000216 0 0.000216005 5 0.000217 5 0.000217005 5 0.000218 5 0.000218005 5 0.000219 5 0.000219005 5 0.00022 5 0.000220005 5 0.000221 5 0.000221005 5 0.000222 5 0.000222005 5 0.000223 5 0.000223005 5 0.000224 5 0.000224005 0 0.000225 0 0.000225005 0 0.000226 0 0.000226005 0 0.000227 0 0.000227005 0 0.000228 0 0.000228005 0 0.000229 0 0.000229005 0 0.00023 0 0.000230005 0 0.000231 0 0.000231005 0 0.000232 0 0.000232005 5 0.000233 5 0.000233005 5 0.000234 5 0.000234005 5 0.000235 5 0.000235005 5 0.000236 5 0.000236005 5 0.000237 5 0.000237005 5 0.000238 5 0.000238005 5 0.000239 5 0.000239005 5 0.00024 5 0.000240005 0 0.000241 0 0.000241005 0 0.000242 0 0.000242005 0 0.000243 0 0.000243005 0 0.000244 0 0.000244005 0 0.000245 0 0.000245005 0 0.000246 0 0.000246005 0 0.000247 0 0.000247005 0 0.000248 0 0.000248005 5 0.000249 5 0.000249005 5 0.00025 5 0.000250005 5 0.000251 5 0.000251005 5 0.000252 5 0.000252005 5 0.000253 5 0.000253005 5 0.000254 5 0.000254005 5 0.000255 5 0.000255005 5)
Vb6 b6 0 PWL(0 0 1e-06 0 1.005e-06 0 2e-06 0 2.005e-06 0 3e-06 0 3.005e-06 0 4e-06 0 4.005e-06 5 5e-06 5 5.005e-06 5 6e-06 5 6.005e-06 5 7e-06 5 7.005e-06 5 8e-06 5 8.005e-06 0 9e-06 0 9.005e-06 0 1e-05 0 1.0005e-05 0 1.1e-05 0 1.1005e-05 0 1.2e-05 0 1.2005e-05 5 1.3e-05 5 1.3005e-05 5 1.4e-05 5 1.4005e-05 5 1.5e-05 5 1.5005e-05 5 1.6e-05 5 1.6005e-05 0 1.7e-05 0 1.7005e-05 0 1.8e-05 0 1.8005e-05 0 1.9e-05 0 1.9005e-05 0 2e-05 0 2.0005e-05 5 2.1e-05 5 2.1005e-05 5 2.2e-05 5 2.2005e-05 5 2.3e-05 5 2.3005e-05 5 2.4e-05 5 2.4005e-05 0 2.5e-05 0 2.5005e-05 0 2.6e-05 0 2.6005e-05 0 2.7e-05 0 2.7005e-05 0 2.8e-05 0 2.8005e-05 5 2.9e-05 5 2.9005e-05 5 3e-05 5 3.0005e-05 5 3.1e-05 5 3.1005e-05 5 3.2e-05 5 3.2005e-05 0 3.3e-05 0 3.3005e-05 0 3.4e-05 0 3.4005e-05 0 3.5e-05 0 3.5005e-05 0 3.6e-05 0 3.6005e-05 5 3.7e-05 5 3.7005e-05 5 3.8e-05 5 3.8005e-05 5 3.9e-05 5 3.9005e-05 5 4e-05 5 4.0005e-05 0 4.1e-05 0 4.1005e-05 0 4.2e-05 0 4.2005e-05 0 4.3e-05 0 4.3005e-05 0 4.4e-05 0 4.4005e-05 5 4.5e-05 5 4.5005e-05 5 4.6e-05 5 4.6005e-05 5 4.7e-05 5 4.7005e-05 5 4.8e-05 5 4.8005e-05 0 4.9e-05 0 4.9005e-05 0 5e-05 0 5.0005e-05 0 5.1e-05 0 5.1005e-05 0 5.2e-05 0 5.2005e-05 5 5.3e-05 5 5.3005e-05 5 5.4e-05 5 5.4005e-05 5 5.5e-05 5 5.5005e-05 5 5.6e-05 5 5.6005e-05 0 5.7e-05 0 5.7005e-05 0 5.8e-05 0 5.8005e-05 0 5.9e-05 0 5.9005e-05 0 6e-05 0 6.0005e-05 5 6.1e-05 5 6.1005e-05 5 6.2e-05 5 6.2005e-05 5 6.3e-05 5 6.3005e-05 5 6.4e-05 5 6.4005e-05 0 6.5e-05 0 6.5005e-05 0 6.6e-05 0 6.6005e-05 0 6.7e-05 0 6.7005e-05 0 6.8e-05 0 6.8005e-05 5 6.9e-05 5 6.9005e-05 5 7e-05 5 7.0005e-05 5 7.1e-05 5 7.1005e-05 5 7.2e-05 5 7.2005e-05 0 7.3e-05 0 7.3005e-05 0 7.4e-05 0 7.4005e-05 0 7.5e-05 0 7.5005e-05 0 7.6e-05 0 7.6005e-05 5 7.7e-05 5 7.7005e-05 5 7.8e-05 5 7.8005e-05 5 7.9e-05 5 7.9005e-05 5 8e-05 5 8.0005e-05 0 8.1e-05 0 8.1005e-05 0 8.2e-05 0 8.2005e-05 0 8.3e-05 0 8.3005e-05 0 8.4e-05 0 8.4005e-05 5 8.5e-05 5 8.5005e-05 5 8.6e-05 5 8.6005e-05 5 8.7e-05 5 8.7005e-05 5 8.8e-05 5 8.8005e-05 0 8.9e-05 0 8.9005e-05 0 9e-05 0 9.0005e-05 0 9.1e-05 0 9.1005e-05 0 9.2e-05 0 9.2005e-05 5 9.3e-05 5 9.3005e-05 5 9.4e-05 5 9.4005e-05 5 9.5e-05 5 9.5005e-05 5 9.6e-05 5 9.6005e-05 0 9.7e-05 0 9.7005e-05 0 9.8e-05 0 9.8005e-05 0 9.9e-05 0 9.9005e-05 0 0.0001 0 0.000100005 5 0.000101 5 0.000101005 5 0.000102 5 0.000102005 5 0.000103 5 0.000103005 5 0.000104 5 0.000104005 0 0.000105 0 0.000105005 0 0.000106 0 0.000106005 0 0.000107 0 0.000107005 0 0.000108 0 0.000108005 5 0.000109 5 0.000109005 5 0.00011 5 0.000110005 5 0.000111 5 0.000111005 5 0.000112 5 0.000112005 0 0.000113 0 0.000113005 0 0.000114 0 0.000114005 0 0.000115 0 0.000115005 0 0.000116 0 0.000116005 5 0.000117 5 0.000117005 5 0.000118 5 0.000118005 5 0.000119 5 0.000119005 5 0.00012 5 0.000120005 0 0.000121 0 0.000121005 0 0.000122 0 0.000122005 0 0.000123 0 0.000123005 0 0.000124 0 0.000124005 5 0.000125 5 0.000125005 5 0.000126 5 0.000126005 5 0.000127 5 0.000127005 5 0.000128 5 0.000128005 0 0.000129 0 0.000129005 0 0.00013 0 0.000130005 0 0.000131 0 0.000131005 0 0.000132 0 0.000132005 5 0.000133 5 0.000133005 5 0.000134 5 0.000134005 5 0.000135 5 0.000135005 5 0.000136 5 0.000136005 0 0.000137 0 0.000137005 0 0.000138 0 0.000138005 0 0.000139 0 0.000139005 0 0.00014 0 0.000140005 5 0.000141 5 0.000141005 5 0.000142 5 0.000142005 5 0.000143 5 0.000143005 5 0.000144 5 0.000144005 0 0.000145 0 0.000145005 0 0.000146 0 0.000146005 0 0.000147 0 0.000147005 0 0.000148 0 0.000148005 5 0.000149 5 0.000149005 5 0.00015 5 0.000150005 5 0.000151 5 0.000151005 5 0.000152 5 0.000152005 0 0.000153 0 0.000153005 0 0.000154 0 0.000154005 0 0.000155 0 0.000155005 0 0.000156 0 0.000156005 5 0.000157 5 0.000157005 5 0.000158 5 0.000158005 5 0.000159 5 0.000159005 5 0.00016 5 0.000160005 0 0.000161 0 0.000161005 0 0.000162 0 0.000162005 0 0.000163 0 0.000163005 0 0.000164 0 0.000164005 5 0.000165 5 0.000165005 5 0.000166 5 0.000166005 5 0.000167 5 0.000167005 5 0.000168 5 0.000168005 0 0.000169 0 0.000169005 0 0.00017 0 0.000170005 0 0.000171 0 0.000171005 0 0.000172 0 0.000172005 5 0.000173 5 0.000173005 5 0.000174 5 0.000174005 5 0.000175 5 0.000175005 5 0.000176 5 0.000176005 0 0.000177 0 0.000177005 0 0.000178 0 0.000178005 0 0.000179 0 0.000179005 0 0.00018 0 0.000180005 5 0.000181 5 0.000181005 5 0.000182 5 0.000182005 5 0.000183 5 0.000183005 5 0.000184 5 0.000184005 0 0.000185 0 0.000185005 0 0.000186 0 0.000186005 0 0.000187 0 0.000187005 0 0.000188 0 0.000188005 5 0.000189 5 0.000189005 5 0.00019 5 0.000190005 5 0.000191 5 0.000191005 5 0.000192 5 0.000192005 0 0.000193 0 0.000193005 0 0.000194 0 0.000194005 0 0.000195 0 0.000195005 0 0.000196 0 0.000196005 5 0.000197 5 0.000197005 5 0.000198 5 0.000198005 5 0.000199 5 0.000199005 5 0.0002 5 0.000200005 0 0.000201 0 0.000201005 0 0.000202 0 0.000202005 0 0.000203 0 0.000203005 0 0.000204 0 0.000204005 5 0.000205 5 0.000205005 5 0.000206 5 0.000206005 5 0.000207 5 0.000207005 5 0.000208 5 0.000208005 0 0.000209 0 0.000209005 0 0.00021 0 0.000210005 0 0.000211 0 0.000211005 0 0.000212 0 0.000212005 5 0.000213 5 0.000213005 5 0.000214 5 0.000214005 5 0.000215 5 0.000215005 5 0.000216 5 0.000216005 0 0.000217 0 0.000217005 0 0.000218 0 0.000218005 0 0.000219 0 0.000219005 0 0.00022 0 0.000220005 5 0.000221 5 0.000221005 5 0.000222 5 0.000222005 5 0.000223 5 0.000223005 5 0.000224 5 0.000224005 0 0.000225 0 0.000225005 0 0.000226 0 0.000226005 0 0.000227 0 0.000227005 0 0.000228 0 0.000228005 5 0.000229 5 0.000229005 5 0.00023 5 0.000230005 5 0.000231 5 0.000231005 5 0.000232 5 0.000232005 0 0.000233 0 0.000233005 0 0.000234 0 0.000234005 0 0.000235 0 0.000235005 0 0.000236 0 0.000236005 5 0.000237 5 0.000237005 5 0.000238 5 0.000238005 5 0.000239 5 0.000239005 5 0.00024 5 0.000240005 0 0.000241 0 0.000241005 0 0.000242 0 0.000242005 0 0.000243 0 0.000243005 0 0.000244 0 0.000244005 5 0.000245 5 0.000245005 5 0.000246 5 0.000246005 5 0.000247 5 0.000247005 5 0.000248 5 0.000248005 0 0.000249 0 0.000249005 0 0.00025 0 0.000250005 0 0.000251 0 0.000251005 0 0.000252 0 0.000252005 5 0.000253 5 0.000253005 5 0.000254 5 0.000254005 5 0.000255 5 0.000255005 5)
Vb7 b7 0 PWL(0 0 1e-06 0 1.005e-06 0 2e-06 0 2.005e-06 5 3e-06 5 3.005e-06 5 4e-06 5 4.005e-06 0 5e-06 0 5.005e-06 0 6e-06 0 6.005e-06 5 7e-06 5 7.005e-06 5 8e-06 5 8.005e-06 0 9e-06 0 9.005e-06 0 1e-05 0 1.0005e-05 5 1.1e-05 5 1.1005e-05 5 1.2e-05 5 1.2005e-05 0 1.3e-05 0 1.3005e-05 0 1.4e-05 0 1.4005e-05 5 1.5e-05 5 1.5005e-05 5 1.6e-05 5 1.6005e-05 0 1.7e-05 0 1.7005e-05 0 1.8e-05 0 1.8005e-05 5 1.9e-05 5 1.9005e-05 5 2e-05 5 2.0005e-05 0 2.1e-05 0 2.1005e-05 0 2.2e-05 0 2.2005e-05 5 2.3e-05 5 2.3005e-05 5 2.4e-05 5 2.4005e-05 0 2.5e-05 0 2.5005e-05 0 2.6e-05 0 2.6005e-05 5 2.7e-05 5 2.7005e-05 5 2.8e-05 5 2.8005e-05 0 2.9e-05 0 2.9005e-05 0 3e-05 0 3.0005e-05 5 3.1e-05 5 3.1005e-05 5 3.2e-05 5 3.2005e-05 0 3.3e-05 0 3.3005e-05 0 3.4e-05 0 3.4005e-05 5 3.5e-05 5 3.5005e-05 5 3.6e-05 5 3.6005e-05 0 3.7e-05 0 3.7005e-05 0 3.8e-05 0 3.8005e-05 5 3.9e-05 5 3.9005e-05 5 4e-05 5 4.0005e-05 0 4.1e-05 0 4.1005e-05 0 4.2e-05 0 4.2005e-05 5 4.3e-05 5 4.3005e-05 5 4.4e-05 5 4.4005e-05 0 4.5e-05 0 4.5005e-05 0 4.6e-05 0 4.6005e-05 5 4.7e-05 5 4.7005e-05 5 4.8e-05 5 4.8005e-05 0 4.9e-05 0 4.9005e-05 0 5e-05 0 5.0005e-05 5 5.1e-05 5 5.1005e-05 5 5.2e-05 5 5.2005e-05 0 5.3e-05 0 5.3005e-05 0 5.4e-05 0 5.4005e-05 5 5.5e-05 5 5.5005e-05 5 5.6e-05 5 5.6005e-05 0 5.7e-05 0 5.7005e-05 0 5.8e-05 0 5.8005e-05 5 5.9e-05 5 5.9005e-05 5 6e-05 5 6.0005e-05 0 6.1e-05 0 6.1005e-05 0 6.2e-05 0 6.2005e-05 5 6.3e-05 5 6.3005e-05 5 6.4e-05 5 6.4005e-05 0 6.5e-05 0 6.5005e-05 0 6.6e-05 0 6.6005e-05 5 6.7e-05 5 6.7005e-05 5 6.8e-05 5 6.8005e-05 0 6.9e-05 0 6.9005e-05 0 7e-05 0 7.0005e-05 5 7.1e-05 5 7.1005e-05 5 7.2e-05 5 7.2005e-05 0 7.3e-05 0 7.3005e-05 0 7.4e-05 0 7.4005e-05 5 7.5e-05 5 7.5005e-05 5 7.6e-05 5 7.6005e-05 0 7.7e-05 0 7.7005e-05 0 7.8e-05 0 7.8005e-05 5 7.9e-05 5 7.9005e-05 5 8e-05 5 8.0005e-05 0 8.1e-05 0 8.1005e-05 0 8.2e-05 0 8.2005e-05 5 8.3e-05 5 8.3005e-05 5 8.4e-05 5 8.4005e-05 0 8.5e-05 0 8.5005e-05 0 8.6e-05 0 8.6005e-05 5 8.7e-05 5 8.7005e-05 5 8.8e-05 5 8.8005e-05 0 8.9e-05 0 8.9005e-05 0 9e-05 0 9.0005e-05 5 9.1e-05 5 9.1005e-05 5 9.2e-05 5 9.2005e-05 0 9.3e-05 0 9.3005e-05 0 9.4e-05 0 9.4005e-05 5 9.5e-05 5 9.5005e-05 5 9.6e-05 5 9.6005e-05 0 9.7e-05 0 9.7005e-05 0 9.8e-05 0 9.8005e-05 5 9.9e-05 5 9.9005e-05 5 0.0001 5 0.000100005 0 0.000101 0 0.000101005 0 0.000102 0 0.000102005 5 0.000103 5 0.000103005 5 0.000104 5 0.000104005 0 0.000105 0 0.000105005 0 0.000106 0 0.000106005 5 0.000107 5 0.000107005 5 0.000108 5 0.000108005 0 0.000109 0 0.000109005 0 0.00011 0 0.000110005 5 0.000111 5 0.000111005 5 0.000112 5 0.000112005 0 0.000113 0 0.000113005 0 0.000114 0 0.000114005 5 0.000115 5 0.000115005 5 0.000116 5 0.000116005 0 0.000117 0 0.000117005 0 0.000118 0 0.000118005 5 0.000119 5 0.000119005 5 0.00012 5 0.000120005 0 0.000121 0 0.000121005 0 0.000122 0 0.000122005 5 0.000123 5 0.000123005 5 0.000124 5 0.000124005 0 0.000125 0 0.000125005 0 0.000126 0 0.000126005 5 0.000127 5 0.000127005 5 0.000128 5 0.000128005 0 0.000129 0 0.000129005 0 0.00013 0 0.000130005 5 0.000131 5 0.000131005 5 0.000132 5 0.000132005 0 0.000133 0 0.000133005 0 0.000134 0 0.000134005 5 0.000135 5 0.000135005 5 0.000136 5 0.000136005 0 0.000137 0 0.000137005 0 0.000138 0 0.000138005 5 0.000139 5 0.000139005 5 0.00014 5 0.000140005 0 0.000141 0 0.000141005 0 0.000142 0 0.000142005 5 0.000143 5 0.000143005 5 0.000144 5 0.000144005 0 0.000145 0 0.000145005 0 0.000146 0 0.000146005 5 0.000147 5 0.000147005 5 0.000148 5 0.000148005 0 0.000149 0 0.000149005 0 0.00015 0 0.000150005 5 0.000151 5 0.000151005 5 0.000152 5 0.000152005 0 0.000153 0 0.000153005 0 0.000154 0 0.000154005 5 0.000155 5 0.000155005 5 0.000156 5 0.000156005 0 0.000157 0 0.000157005 0 0.000158 0 0.000158005 5 0.000159 5 0.000159005 5 0.00016 5 0.000160005 0 0.000161 0 0.000161005 0 0.000162 0 0.000162005 5 0.000163 5 0.000163005 5 0.000164 5 0.000164005 0 0.000165 0 0.000165005 0 0.000166 0 0.000166005 5 0.000167 5 0.000167005 5 0.000168 5 0.000168005 0 0.000169 0 0.000169005 0 0.00017 0 0.000170005 5 0.000171 5 0.000171005 5 0.000172 5 0.000172005 0 0.000173 0 0.000173005 0 0.000174 0 0.000174005 5 0.000175 5 0.000175005 5 0.000176 5 0.000176005 0 0.000177 0 0.000177005 0 0.000178 0 0.000178005 5 0.000179 5 0.000179005 5 0.00018 5 0.000180005 0 0.000181 0 0.000181005 0 0.000182 0 0.000182005 5 0.000183 5 0.000183005 5 0.000184 5 0.000184005 0 0.000185 0 0.000185005 0 0.000186 0 0.000186005 5 0.000187 5 0.000187005 5 0.000188 5 0.000188005 0 0.000189 0 0.000189005 0 0.00019 0 0.000190005 5 0.000191 5 0.000191005 5 0.000192 5 0.000192005 0 0.000193 0 0.000193005 0 0.000194 0 0.000194005 5 0.000195 5 0.000195005 5 0.000196 5 0.000196005 0 0.000197 0 0.000197005 0 0.000198 0 0.000198005 5 0.000199 5 0.000199005 5 0.0002 5 0.000200005 0 0.000201 0 0.000201005 0 0.000202 0 0.000202005 5 0.000203 5 0.000203005 5 0.000204 5 0.000204005 0 0.000205 0 0.000205005 0 0.000206 0 0.000206005 5 0.000207 5 0.000207005 5 0.000208 5 0.000208005 0 0.000209 0 0.000209005 0 0.00021 0 0.000210005 5 0.000211 5 0.000211005 5 0.000212 5 0.000212005 0 0.000213 0 0.000213005 0 0.000214 0 0.000214005 5 0.000215 5 0.000215005 5 0.000216 5 0.000216005 0 0.000217 0 0.000217005 0 0.000218 0 0.000218005 5 0.000219 5 0.000219005 5 0.00022 5 0.000220005 0 0.000221 0 0.000221005 0 0.000222 0 0.000222005 5 0.000223 5 0.000223005 5 0.000224 5 0.000224005 0 0.000225 0 0.000225005 0 0.000226 0 0.000226005 5 0.000227 5 0.000227005 5 0.000228 5 0.000228005 0 0.000229 0 0.000229005 0 0.00023 0 0.000230005 5 0.000231 5 0.000231005 5 0.000232 5 0.000232005 0 0.000233 0 0.000233005 0 0.000234 0 0.000234005 5 0.000235 5 0.000235005 5 0.000236 5 0.000236005 0 0.000237 0 0.000237005 0 0.000238 0 0.000238005 5 0.000239 5 0.000239005 5 0.00024 5 0.000240005 0 0.000241 0 0.000241005 0 0.000242 0 0.000242005 5 0.000243 5 0.000243005 5 0.000244 5 0.000244005 0 0.000245 0 0.000245005 0 0.000246 0 0.000246005 5 0.000247 5 0.000247005 5 0.000248 5 0.000248005 0 0.000249 0 0.000249005 0 0.00025 0 0.000250005 5 0.000251 5 0.000251005 5 0.000252 5 0.000252005 0 0.000253 0 0.000253005 0 0.000254 0 0.000254005 5 0.000255 5 0.000255005 5)
Vb8 b8 0 PWL(0 0 1e-06 0 1.005e-06 5 2e-06 5 2.005e-06 0 3e-06 0 3.005e-06 5 4e-06 5 4.005e-06 0 5e-06 0 5.005e-06 5 6e-06 5 6.005e-06 0 7e-06 0 7.005e-06 5 8e-06 5 8.005e-06 0 9e-06 0 9.005e-06 5 1e-05 5 1.0005e-05 0 1.1e-05 0 1.1005e-05 5 1.2e-05 5 1.2005e-05 0 1.3e-05 0 1.3005e-05 5 1.4e-05 5 1.4005e-05 0 1.5e-05 0 1.5005e-05 5 1.6e-05 5 1.6005e-05 0 1.7e-05 0 1.7005e-05 5 1.8e-05 5 1.8005e-05 0 1.9e-05 0 1.9005e-05 5 2e-05 5 2.0005e-05 0 2.1e-05 0 2.1005e-05 5 2.2e-05 5 2.2005e-05 0 2.3e-05 0 2.3005e-05 5 2.4e-05 5 2.4005e-05 0 2.5e-05 0 2.5005e-05 5 2.6e-05 5 2.6005e-05 0 2.7e-05 0 2.7005e-05 5 2.8e-05 5 2.8005e-05 0 2.9e-05 0 2.9005e-05 5 3e-05 5 3.0005e-05 0 3.1e-05 0 3.1005e-05 5 3.2e-05 5 3.2005e-05 0 3.3e-05 0 3.3005e-05 5 3.4e-05 5 3.4005e-05 0 3.5e-05 0 3.5005e-05 5 3.6e-05 5 3.6005e-05 0 3.7e-05 0 3.7005e-05 5 3.8e-05 5 3.8005e-05 0 3.9e-05 0 3.9005e-05 5 4e-05 5 4.0005e-05 0 4.1e-05 0 4.1005e-05 5 4.2e-05 5 4.2005e-05 0 4.3e-05 0 4.3005e-05 5 4.4e-05 5 4.4005e-05 0 4.5e-05 0 4.5005e-05 5 4.6e-05 5 4.6005e-05 0 4.7e-05 0 4.7005e-05 5 4.8e-05 5 4.8005e-05 0 4.9e-05 0 4.9005e-05 5 5e-05 5 5.0005e-05 0 5.1e-05 0 5.1005e-05 5 5.2e-05 5 5.2005e-05 0 5.3e-05 0 5.3005e-05 5 5.4e-05 5 5.4005e-05 0 5.5e-05 0 5.5005e-05 5 5.6e-05 5 5.6005e-05 0 5.7e-05 0 5.7005e-05 5 5.8e-05 5 5.8005e-05 0 5.9e-05 0 5.9005e-05 5 6e-05 5 6.0005e-05 0 6.1e-05 0 6.1005e-05 5 6.2e-05 5 6.2005e-05 0 6.3e-05 0 6.3005e-05 5 6.4e-05 5 6.4005e-05 0 6.5e-05 0 6.5005e-05 5 6.6e-05 5 6.6005e-05 0 6.7e-05 0 6.7005e-05 5 6.8e-05 5 6.8005e-05 0 6.9e-05 0 6.9005e-05 5 7e-05 5 7.0005e-05 0 7.1e-05 0 7.1005e-05 5 7.2e-05 5 7.2005e-05 0 7.3e-05 0 7.3005e-05 5 7.4e-05 5 7.4005e-05 0 7.5e-05 0 7.5005e-05 5 7.6e-05 5 7.6005e-05 0 7.7e-05 0 7.7005e-05 5 7.8e-05 5 7.8005e-05 0 7.9e-05 0 7.9005e-05 5 8e-05 5 8.0005e-05 0 8.1e-05 0 8.1005e-05 5 8.2e-05 5 8.2005e-05 0 8.3e-05 0 8.3005e-05 5 8.4e-05 5 8.4005e-05 0 8.5e-05 0 8.5005e-05 5 8.6e-05 5 8.6005e-05 0 8.7e-05 0 8.7005e-05 5 8.8e-05 5 8.8005e-05 0 8.9e-05 0 8.9005e-05 5 9e-05 5 9.0005e-05 0 9.1e-05 0 9.1005e-05 5 9.2e-05 5 9.2005e-05 0 9.3e-05 0 9.3005e-05 5 9.4e-05 5 9.4005e-05 0 9.5e-05 0 9.5005e-05 5 9.6e-05 5 9.6005e-05 0 9.7e-05 0 9.7005e-05 5 9.8e-05 5 9.8005e-05 0 9.9e-05 0 9.9005e-05 5 0.0001 5 0.000100005 0 0.000101 0 0.000101005 5 0.000102 5 0.000102005 0 0.000103 0 0.000103005 5 0.000104 5 0.000104005 0 0.000105 0 0.000105005 5 0.000106 5 0.000106005 0 0.000107 0 0.000107005 5 0.000108 5 0.000108005 0 0.000109 0 0.000109005 5 0.00011 5 0.000110005 0 0.000111 0 0.000111005 5 0.000112 5 0.000112005 0 0.000113 0 0.000113005 5 0.000114 5 0.000114005 0 0.000115 0 0.000115005 5 0.000116 5 0.000116005 0 0.000117 0 0.000117005 5 0.000118 5 0.000118005 0 0.000119 0 0.000119005 5 0.00012 5 0.000120005 0 0.000121 0 0.000121005 5 0.000122 5 0.000122005 0 0.000123 0 0.000123005 5 0.000124 5 0.000124005 0 0.000125 0 0.000125005 5 0.000126 5 0.000126005 0 0.000127 0 0.000127005 5 0.000128 5 0.000128005 0 0.000129 0 0.000129005 5 0.00013 5 0.000130005 0 0.000131 0 0.000131005 5 0.000132 5 0.000132005 0 0.000133 0 0.000133005 5 0.000134 5 0.000134005 0 0.000135 0 0.000135005 5 0.000136 5 0.000136005 0 0.000137 0 0.000137005 5 0.000138 5 0.000138005 0 0.000139 0 0.000139005 5 0.00014 5 0.000140005 0 0.000141 0 0.000141005 5 0.000142 5 0.000142005 0 0.000143 0 0.000143005 5 0.000144 5 0.000144005 0 0.000145 0 0.000145005 5 0.000146 5 0.000146005 0 0.000147 0 0.000147005 5 0.000148 5 0.000148005 0 0.000149 0 0.000149005 5 0.00015 5 0.000150005 0 0.000151 0 0.000151005 5 0.000152 5 0.000152005 0 0.000153 0 0.000153005 5 0.000154 5 0.000154005 0 0.000155 0 0.000155005 5 0.000156 5 0.000156005 0 0.000157 0 0.000157005 5 0.000158 5 0.000158005 0 0.000159 0 0.000159005 5 0.00016 5 0.000160005 0 0.000161 0 0.000161005 5 0.000162 5 0.000162005 0 0.000163 0 0.000163005 5 0.000164 5 0.000164005 0 0.000165 0 0.000165005 5 0.000166 5 0.000166005 0 0.000167 0 0.000167005 5 0.000168 5 0.000168005 0 0.000169 0 0.000169005 5 0.00017 5 0.000170005 0 0.000171 0 0.000171005 5 0.000172 5 0.000172005 0 0.000173 0 0.000173005 5 0.000174 5 0.000174005 0 0.000175 0 0.000175005 5 0.000176 5 0.000176005 0 0.000177 0 0.000177005 5 0.000178 5 0.000178005 0 0.000179 0 0.000179005 5 0.00018 5 0.000180005 0 0.000181 0 0.000181005 5 0.000182 5 0.000182005 0 0.000183 0 0.000183005 5 0.000184 5 0.000184005 0 0.000185 0 0.000185005 5 0.000186 5 0.000186005 0 0.000187 0 0.000187005 5 0.000188 5 0.000188005 0 0.000189 0 0.000189005 5 0.00019 5 0.000190005 0 0.000191 0 0.000191005 5 0.000192 5 0.000192005 0 0.000193 0 0.000193005 5 0.000194 5 0.000194005 0 0.000195 0 0.000195005 5 0.000196 5 0.000196005 0 0.000197 0 0.000197005 5 0.000198 5 0.000198005 0 0.000199 0 0.000199005 5 0.0002 5 0.000200005 0 0.000201 0 0.000201005 5 0.000202 5 0.000202005 0 0.000203 0 0.000203005 5 0.000204 5 0.000204005 0 0.000205 0 0.000205005 5 0.000206 5 0.000206005 0 0.000207 0 0.000207005 5 0.000208 5 0.000208005 0 0.000209 0 0.000209005 5 0.00021 5 0.000210005 0 0.000211 0 0.000211005 5 0.000212 5 0.000212005 0 0.000213 0 0.000213005 5 0.000214 5 0.000214005 0 0.000215 0 0.000215005 5 0.000216 5 0.000216005 0 0.000217 0 0.000217005 5 0.000218 5 0.000218005 0 0.000219 0 0.000219005 5 0.00022 5 0.000220005 0 0.000221 0 0.000221005 5 0.000222 5 0.000222005 0 0.000223 0 0.000223005 5 0.000224 5 0.000224005 0 0.000225 0 0.000225005 5 0.000226 5 0.000226005 0 0.000227 0 0.000227005 5 0.000228 5 0.000228005 0 0.000229 0 0.000229005 5 0.00023 5 0.000230005 0 0.000231 0 0.000231005 5 0.000232 5 0.000232005 0 0.000233 0 0.000233005 5 0.000234 5 0.000234005 0 0.000235 0 0.000235005 5 0.000236 5 0.000236005 0 0.000237 0 0.000237005 5 0.000238 5 0.000238005 0 0.000239 0 0.000239005 5 0.00024 5 0.000240005 0 0.000241 0 0.000241005 5 0.000242 5 0.000242005 0 0.000243 0 0.000243005 5 0.000244 5 0.000244005 0 0.000245 0 0.000245005 5 0.000246 5 0.000246005 0 0.000247 0 0.000247005 5 0.000248 5 0.000248005 0 0.000249 0 0.000249005 5 0.00025 5 0.000250005 0 0.000251 0 0.000251005 5 0.000252 5 0.000252005 0 0.000253 0 0.000253005 5 0.000254 5 0.000254005 0 0.000255 0 0.000255005 5)
R14 vr r14 5k
R15 r15 0 5k
* outputs held at 0 V by ammeters (virtual grounds)
X1 0 nob vm no b1 b2 b3 b4 b5 b6 b7 b8 vp r14 r15 cc DAC0800
Cc cc vm 10n
Vio no 0 0
Viob nob 0 0
* Figure 23: IOUT to the inverting input (RL = 5k feedback), IOUTB to
* the non-inverting input with RL' = 5k to ground; ideal op amp
R14b vr r14b 5k
R15b r15b 0 5k
X2 0 pp vm nn b1 b2 b3 b4 b5 b6 b7 b8 vp r14b r15b ccb DAC0800
Ccb ccb vm 10n
Rlb pp 0 5k
Rfb nn eo 5k
Eop eo 0 pp nn 1e6
.control
set noaskquit
echo "--- test 02: 256 codes, offset binary ---"
tran 10n 256u 0 100n
let io = -i(Vio)
let iob = -i(Viob)
linearize io iob v(eo)
let n = length(time)
let dt = time[1]-time[0]
let k = floor((0.9u + 1u*vector(256))/dt + 0.5)
let s = vector(256)
let sb = vector(256)
let e = vector(256)
let j = 0
while j < 256
  let s[j] = io[k[j]]
  let sb[j] = iob[k[j]]
  let e[j] = v(eo)[k[j]]
  let j = j + 1
end
let lsb = 2m/256
let ifs = s + sb
let step = (s[1,255] - s[0,254])/lsb
let smin = minimum(step)
let smax = maximum(step)
let ifsdev = maximum(abs(ifs - 255*lsb))
let inl = maximum(abs(s - lsb*vector(256) - 0.2u))/lsb
print smin smax ifsdev inl
if (smin > 0.5) & (smax < 1.5) & (ifsdev < 0.5*lsb)
  echo "PASS 02a 256 codes: monotonic, steps $&smin .. $&smax LSB, IOUT + IOUTB = IFS within $&ifsdev A"
else
  echo "FAIL 02a steps $&smin $&smax ifs $&ifsdev"
end
if inl < 0.5
  echo "PASS 02b linearity: worst deviation from the ideal line $&inl LSB"
else
  echo "FAIL 02b INL $&inl LSB"
end
let e255 = e[255]
let e128 = e[128]
let e127 = e[127]
let e0 = e[0]
let e254 = e[254]
let e1 = e[1]
if (abs(e255-9.960) < 0.039) & (abs(e254-9.880) < 0.039) & (abs(e128-0.040) < 0.039) & (abs(e127+0.040) < 0.039) & (abs(e1+9.880) < 0.039) & (abs(e0+9.960) < 0.039)
  echo "PASS 02c table 3 (offset binary): $&e255 / $&e254 / $&e128 / $&e127 / $&e1 / $&e0 V (+9.960 / +9.880 / +0.040 / -0.040 / -9.880 / -9.960)"
else
  echo "FAIL 02c $&e255 $&e254 $&e128 $&e127 $&e1 $&e0"
end
quit
.endc
.end
